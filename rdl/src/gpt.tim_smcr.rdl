`ifndef TIM_SMCR_REG
`define TIM_SMCR_REG

reg TIM_SMCR {
  name = "Регистр управления Master/Slave контроллером";
  field {
    name = "Полярность внешнего триггера";
    desc = "Этот бит выбирает полярность сигнала ETR для операций триггера<br>
      0: ETR неинвертированный, активен по высокому уровню или фронту<br>
      1: ETR инвертированный, активен по низкому уровню или спаду";
    hw = r;
    sw = rw;
} ETP[15:15];

field {
    name = "Разрешение внешнего тактирования";
    desc = "Этот бит разрешает режим внешнего тактирования 2<br>
      0: Режим внешнего тактирования 2 запрещен<br>
      1: Режим внешнего тактирования 2 разрешен. Счетчик тактируется любым активным фронтом сигнала ETRF<br>
      <b>Примечание 1:</b> Установка бита ECE имеет тот же эффект, что и выбор внешнего тактирования 1 с подключением TRGI к ETRF (SMS=111 и TS=111)<br>
      <b>Примечание 2:</b> Возможно одновременное использование внешнего тактирования 2 со следующими ведомыми режимами: режим сброса, режим стробирования и режим триггера. Однако в этом случае TRGI не должен быть подключен к ETRF (биты TS не должны быть 111)<br>
      <b>Примечание 3:</b> Если одновременно разрешены внешний режим тактирования 1 и внешний режим тактирования 2, входом внешнего тактирования является ETRF";
    hw = r;
    sw = rw;
} ECE[14:14];

field {
    name = "Предделитель внешнего триггера";
    desc = "Частота сигнала внешнего триггера ETRP должна быть не более 1/4 частоты CK_INT. Предделитель может быть включен для уменьшения частоты ETRP. Это полезно при подаче быстрых внешних тактовых сигналов<br>
      00: Предделитель выключен<br>
      01: Частота ETRP делится на 2<br>
      10: Частота ETRP делится на 4<br>
      11: Частота ETRP делится на 8";
    hw = r;
    sw = rw;
} ETPS[13:12];

field {
    name = "Фильтр внешнего триггера";
    desc = "Эта битовая группа определяет частоту дискретизации сигнала ETRP и длину цифрового фильтра, применяемого к ETRP. Цифровой фильтр состоит из счетчика событий, в котором N последовательных событий необходимо для подтверждения перехода на выходе:<br>
      0000: Без фильтра, дискретизация на f<sub>DTS</sub><br>
      0001: f<sub>SAMPLING</sub> = f<sub>CK_INT</sub>, N=2<br>
      0010: f<sub>SAMPLING</sub> = f<sub>CK_INT</sub>, N=4<br>
      0011: f<sub>SAMPLING</sub> = f<sub>CK_INT</sub>, N=8<br>
      0100: f<sub>SAMPLING</sub> = f<sub>DTS</sub>/2, N=6<br>
      0101: f<sub>SAMPLING</sub> = f<sub>DTS</sub>/2, N=8<br>
      0110: f<sub>SAMPLING</sub> = f<sub>DTS</sub>/4, N=6<br>
      0111: f<sub>SAMPLING</sub> = f<sub>DTS</sub>/4, N=8<br>
      1000: f<sub>SAMPLING</sub> = f<sub>DTS</sub>/8, N=6<br>
      1001: f<sub>SAMPLING</sub> = f<sub>DTS</sub>/8, N=8<br>
      1010: f<sub>SAMPLING</sub> = f<sub>DTS</sub>/16, N=5<br>
      1011: f<sub>SAMPLING</sub> = f<sub>DTS</sub>/16, N=6<br>
      1100: f<sub>SAMPLING</sub> = f<sub>DTS</sub>/16, N=8<br>
      1101: f<sub>SAMPLING</sub> = f<sub>DTS</sub>/32, N=5<br>
      1110: f<sub>SAMPLING</sub> = f<sub>DTS</sub>/32, N=6<br>
      1111: f<sub>SAMPLING</sub> = f<sub>DTS</sub>/32, N=8";
    hw = r;
    sw = rw;
} ETF[11:8];

field {
    name = "Режим Ведущий/Ведомый";
    desc = "0: Никакого действия<br>
            1: Эффект события на входе триггера (TRGI) задерживается для обеспечения идеальной синхронизации между текущим таймером и его ведомыми (через TRGO). Полезно, если необходимо синхронизировать несколько таймеров по одному внешнему событию";
    hw = r;
    sw = rw;
} MSM[7:7];

field {
    name = "Выбор триггера";
    desc = "Эта битовая группа выбирает вход триггера для синхронизации счетчика:<br>
      000: Внутренний триггер 0 (ITR0)<br>
      001: Внутренний триггер 1 (ITR1)<br>
      010: Внутренний триггер 2 (ITR2)<br>
      011: Внутренний триггер 3 (ITR3)<br>
      100: Детектор фронтов T11 (T11F_ED)<br>
      101: Фильтрованный вход таймера 1 (T11FP1)<br>
      110: Фильтрованный вход таймера 2 (T12FP2)<br>
      111: Внешний вход триггера (ETRF)<br>
      <i>Примечание: Эти биты должны изменяться только когда они не используются (например, когда SMS=000) чтобы избежать некорректного детектирования фронтов во время перехода.</i>";
    hw = r;
    sw = rw;
} TS[6:4];

field {
    name = "Выбор ведомого режима";
    desc = "Когда выбраны внешние сигналы, активный фронт сигнала триггера (TRGI) связан с полярностью, выбранной на внешнем входе:<br>
      000: Ведомый режим отключен - если CEN = '1', то предделитель тактируется непосредственно от внутреннего тактового сигнала<br>
      001: Режим энкодера 1 - Счетчик считает вверх/вниз по фронту T11FP1 в зависимости от уровня T12FP2<br>
      010: Режим энкодера 2 - Счетчик считает вверх/вниз по фронту T12FP2 в зависимости от уровня T11FP1<br>
      011: Режим энкодера 3 - Счетчик считает вверх/вниз по обоим фронтам T11FP1 и T12FP2 в зависимости от уровня другого входа<br>
      100: Режим сброса - Фронт выбранного входа триггера (TRGI) переинициализирует счетчик и генерирует обновление регистров<br>
      101: Режим стробирования - Тактирование счетчика разрешено, когда вход триггера (TRGI) находится на высоком уровне. Счетчик останавливается (но не сбрасывается), как только триггер переходит на низкий уровень. Контролируются как запуск, так и остановка счетчика<br>
      110: Триггерный режим - Счетчик запускается по фронту триггера TRGI (но не сбрасывается). Контролируется только запуск счетчика<br>
      111: Режим внешнего тактирования 1 - Фронты выбранного триггера (TRGI) тактируют счетчик<br>
      <i>Примечание: Режим стробирования не должен использоваться, если выбран T11F_ED в качестве входа триггера (TS=100). Действительно, T11F_ED выдает 1 импульс для каждого перехода на T11F, тогда как режим стробирования проверяет уровень сигнала триггера.</i>";
    hw = r;
    sw = rw;
} SMS[2:0];

field {
    sw = r;
    hw = r;
} RESERVED[3:3] = 0;

};
`endif // TIM_SMCR_REG