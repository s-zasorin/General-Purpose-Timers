`ifndef TIM_SR_REG 
`define TIM_SR_REG

reg TIM_SR {
    name = "Регистр статуса";
    desc = "Регистр состояния";
    regwidth = 32;
    
    field {
      name = "reserved_15_13";
      desc = "Зарезервирован, должен сохранять значение сброса";
      hw = r;
      sw = r;
      reset = 0;
    } reserved_15_13 [15:13];
    
    field {
      name = "CC4OF";
      desc = "Флаг перезахвата Capture/Compare 4 - см. описание CC1OF";
      hw = rw;
      sw = rw;
    } CC4OF [12:12];
    
    field {
      name = "CC3OF";
      desc = "Флаг перезахвата Capture/Compare 3 - см. описание CC1OF";
      hw = rw;
      sw = rw;
    } CC3OF [11:11];
    
    field {
      name = "CC2OF";
      desc = "Флаг перезахвата Capture/Compare 2 - см. описание CC1OF";
      hw = rw;
      sw = rw;
    } CC2OF [10:10];
    
    field {
      name = "CC1OF";
      desc = "Флаг перезахвата Capture/Compare 1. Устанавливается аппаратно только когда соответствующий канал настроен в режиме захвата по входу. Сбрасывается программно записью '0'. 0: Перезахват не обнаружен; 1: Значение счетчика захвачено в регистр TIMx_CCR1 когда флаг CC1IF уже был установлен";
      hw = rw;
      sw = rw;
    } CC1OF [9:9];
    
    field {
      name = "reserved_8_7";
      desc = "Зарезервирован, должен сохранять значение сброса";
      hw = r;
      sw = r;
      reset = 0;
    } reserved_8_7 [8:7];
    
    field {
      name = "TIF";
      desc = "Флаг прерывания по триггеру. Устанавливается аппаратно при событии триггера (обнаружен активный фронт на входе TRGI когда контроллер ведомого режима включен во всех режимах кроме стробирующего). Устанавливается когда счетчик запускается или останавливается в стробирующем режиме. Сбрасывается программно. 0: Событие триггера не произошло; 1: Ожидает обработки прерывание по триггеру";
      hw = rw;
      sw = rw;
    } TIF [6:6];
    
    field {
      name = "reserved_5";
      desc = "Зарезервирован, должен сохранять значение сброса";
      hw = r;
      sw = r;
      reset = 0;
    } reserved_5 [5:5];
    
    field {
      name = "CC4IF";
      desc = "Флаг прерывания Capture/Compare 4 - см. описание CC1IF";
      hw = rw;
      sw = rw;
    } CC4IF [4:4];
    
    field {
      name = "CC3IF";
      desc = "Флаг прерывания Capture/Compare 3 - см. описание CC1IF";
      hw = rw;
      sw = rw;
    } CC3IF [3:3];
    
    field {
      name = "CC2IF";
      desc = "Флаг прерывания Capture/Compare 2 - см. описание CC1IF";
      hw = rw;
      sw = rw;
    } CC2IF [2:2];
    
    field {
      name = "CC1IF";
      desc = "Флаг прерывания Capture/Compare 1.<br> 
        <b>Выход:<b> устанавливается аппаратно при совпадении счетчика со значением сравнения. Сбрасывается программно.<br>
        0: Совпадения нет;<br>
        1: CNT совпадает с CCR1. 
        <b>Вход:<b> устанавливается аппаратно при захвате. Сбрасывается программно или чтением CCR1.<br>
        0: Захват не произошел;<br>
        1: Значение счетчика захвачено в CCR1";
      hw = rw;
      sw = rw;
    } CC1IF [1:1];
    
    field {
      name = "UIF";
      desc = "Флаг прерывания по обновлению. Устанавливается аппаратно при событии обновления. Сбрасывается программно. <br>
      0: Обновления не произошло;<br>
      1: Ожидает обработки прерывание по обновлению. Устанавливается при: переполнении/антипереполнении (TIM2-TIM5) если UDIS=0; переинициализации CNT программно (UG=1) если URS=0 и UDIS=0; переинициализации CNT событием триггера если URS=0 и UDIS=0";
      hw = rw;
      sw = rw;
    } UIF [0:0];
};

`endif // TIM_SR_REG