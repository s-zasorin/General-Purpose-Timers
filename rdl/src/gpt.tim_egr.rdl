`ifndef TIM_EGR_REG
`define TIM_EGR_REG

reg TIM_EGR {
    name = "Регистр генерации событий";
    regwidth = 16;
    
    field {
      name = "reserved_15_7";
      desc = "Зарезервирован, должен сохранять значение сброса";
      hw = r;
      sw = r;
      reset = 0;
    } reserved_15_7 [15:7];
    
    field {
      name = "TG";
      desc = "Генерация триггера. Устанавливается программно для генерации события, автоматически сбрасывается аппаратно.<br>
      0: Действия нет;<br>
      1: Флаг TIF устанавливается в регистре TIMx_SR. Соответствующее прерывание или передача DMA может произойти если разрешены";
      hw = rw;
      sw = rw;
    } TG [6:6];
    
    field {
      name = "reserved_5";
      desc = "Зарезервирован, должен сохранять значение сброса";
      hw = r;
      sw = r;
      reset = 0;
    } reserved_5 [5:5];
    
    field {
      name = "CC4G";
      desc = "Генерация Capture/Compare 4 - см. описание CC1G";
      hw = rw;
      sw = rw;
    } CC4G [4:4];
    
    field {
      name = "CC3G";
      desc = "Генерация Capture/Compare 3 - см. описание CC1G";
      hw = rw;
      sw = rw;
    } CC3G [3:3];
    
    field {
      name = "CC2G";
      desc = "Генерация Capture/Compare 2 - см. описание CC1G";
      hw = rw;
      sw = rw;
    } CC2G [2:2];
    
    field {
      name = "CC1G";
      desc = "Генерация Capture/Compare 1. Устанавливается программно для генерации события, автоматически сбрасывается аппаратно.<br>
      0: Действия нет;<br>
      1: Событие захвата/сравнения генерируется на канале 1. 
      <b>Выход:<b> флаг CC1IF устанавливается, отправляется соответствующее прерывание или запрос DMA если разрешены.<br>
      <b>Вход:<b> текущее значение счетчика захватывается в TIMx_CCR1, устанавливается флаг CC1IF, отправляется соответствующее прерывание или запрос DMA если разрешены, флаг CC1OF устанавливается если флаг CC1IF уже был установлен";
      hw = rw;
      sw = rw;
    } CC1G [1:1];
    
    field {
      name = "UG";
      desc = "Генерация обновления. Устанавливается программно, автоматически сбрасывается аппаратно.<br>
      0: Действия нет;<br>
      1: Реинициализирует счетчик и генерирует обновление регистров. Счетчик предделителя также сбрасывается (коэффициент предделителя не меняется). Счетчик очищается если выбран режим центрального выравнивания или если DIR=0 (счет вверх), иначе принимает значение авто-перезагрузки (TIMx_ARR) если DIR=1 (счет вниз)";
      hw = rw;
      sw = rw;
    } UG [0:0];
  };

`endif // TIM_EGR_REG