`ifndef TIM_CCMR1_REG
`define TIM_CCMR1_REG

reg TIM_CCMR {
  name = "Регистр режима захвата/сравнения ";
  desc = "Каналы могут использоваться в режиме входа (захват) или в режиме выхода (сравнение). Направление канала определяется настройкой соответствующих битов CCxS. 
  Все остальные биты этого регистра имеют разную функцию в режиме входа и выхода. 
  OCxx описывает функцию бита когда канал настроен как выход, ICxx описывает функцию когда канал настроен как вход";
  field {
    name = "OC2CE/IC2F[3]";
    desc = "В зависимости от режима, в котором работает канал таймера (вход/выход) данное поле может быть:<br>
    <b>OC2CE<b> — Сигнал разрешение очистки выходного сигнала с помощью ETRF. <br>
    <b>IC2F[3]<b> — Старший бит поля, которое настраивает коэффициент фильтрации для цифрового фильтра на входе TI2.";
    hw = rw;
    sw = rw;
  } OC2CE_IC2F3[15:15];
  
  field {
    name = "OC2M/IC2F[2:0]";
    desc = "Данное поле может являться полем для настройки выходного сигнала (OC2M), либо являться младшей частью поля IC2F для настройки фильтра";
    hw = rw;
    sw = rw;
  } OC2M_IC2F[14:12];

  field {
    name = "OC2PE/IC2PSC[1]";
    desc = "Если это поле используется как OC2PE, то оно управляет включением или отключением предварительной загрузки регистра CCR2.
            Если канал работает в режиме входа, то это поле является старшим битом поля IC2PSC, которое настраивает коэффициент деления предделителя.";
    hw = rw;
    sw = rw;
  } OC2PE_IC2PSC1[11:11];

  field {
    name = "OC2FE/IC2PSC[0]";
    desc = "Это поле может быть полем OC2FE, с помощью которого можно включить режим быстрого формирования на выходе CC2 — Обычно нужно дождаться совадения CNT и CCR2, 
    но в этом режиме внешний триггер имеет такой же эффект, как и равенство CNT и CCR2, таким образом сигнал на выходе формируется намного быстрее.<br>
    <b>В другом случае<b> это поле может быть младшим битом поля IC2PSC.";
    hw = rw;
    sw = rw;
  } OC2FE_IC2PSC0[10:10];

  field {
    name = "CC2S";
    desc = "С помощью этого поля происход настройка канала в режим входа или выхода.<br>
    00: Канал 2 настроен как выход.<br>
    01: Канал 2 настроен как вход. Вход привязан к выводу TI2.<br>
    10: Канал 2 настроен как вход. Вход привязан к выводу TI1.<br>
    11: Канал 2 настроен как вход. Вход привязан к TRC.";
    hw = rw;
    sw = rw;
  } CC2S[9:8];

  field {
    name = "OC1CE/IC1F[3]";
    desc = "В зависимости от режима, в котором работает канал таймера (вход/выход) данное поле может быть:<br>
    <b>OC1CE<b> — Сигнал разрешение очистки выходного сигнала с помощью ETRF. <br>
    <b>IC1F[3]<b> — Старший бит поля, которое настраивает коэффициент фильтрации для цифрового фильтра на входе TI1.";
    hw = rw;
    sw = rw;
  } OC1CE_IC1F3[7:7];

  field {
    name = "OC1M/IC1F[2:0]";
    desc = "Данное поле может являться полем для настройки выходного сигнала (OC1M), либо являться младшей частью поля IC1F для настройки фильтра";
    hw = rw;
    sw = rw;
  } OC1M_IC1F[6:4];

  field {
    name = "OC1PE/IC1PSC[1]";
    desc = "Если это поле используется как OC1PE, то оно управляет включением или отключением предварительной загрузки регистра CCR1.
            Если канал работает в режиме входа, то это поле является старшим битом поля IC1PSC, которое настраивает коэффициент деления предделителя.";
    hw = rw;
    sw = rw;
  } OC1PE_IC1PSC1[3:3];

  field {
    name = "OC1FE/IC1PSC[0]";
    desc = "Это поле может быть полем OC1FE, с помощью которого можно включить режим быстрого формирования на выходе CC1 — Обычно нужно дождаться совадения CNT и CCR1, 
    но в этом режиме внешний триггер имеет такой же эффект, как и равенство CNT и CCR1, таким образом сигнал на выходе формируется намного быстрее.<br>
    <b>В другом случае<b> это поле может быть младшим битом поля IC1PSC.";
    hw = rw;
    sw = rw;
  } OC1FE_IC1PSC0[2:2];

  field {
    name = "CC1S";
    desc = "С помощью этого поля происход настройка канала в режим входа или выхода.<br>
    00: Канал 1 настроен как выход.<br>
    01: Канал 1 настроен как вход. Вход привязан к выводу TI1.<br>
    10: Канал 1 настроен как вход. Вход привязан к выводу TI1.<br>
    11: Канал 1 настроен как вход. Вход привязан к TRC.";
    hw = rw;
    sw = rw;
  } CC1S[1:0];
};

`endif