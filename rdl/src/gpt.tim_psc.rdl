`ifndef TIM_PSC_REG
`define TIM_PSC_REG

reg TIM_PSC {
  name = "Регистр предделителя";
  desc = "Данный регистр является Preload регистром для предделителя. Значение из этого регистра записывается в активный (теневой) регистр, когда происходит событие обновления
  (UEV).";
  field {
    name = "PSC";
    hw = rw;
    sw = rw;
  } PSC[31:0];
};

`endif // TIM_PSC_REG